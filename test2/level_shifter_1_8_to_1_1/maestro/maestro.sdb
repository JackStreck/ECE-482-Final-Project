ADE simulation setup
Run mode: Single Run, Sweeps and Corners
Tests:
  test2_level_shifter_1_8_to_1_1_1: test2/level_shifter_1_8_to_1_1/schematic, simulator hspiceD
