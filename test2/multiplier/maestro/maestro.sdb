ADE simulation setup
Run mode: Single Run, Sweeps and Corners
Tests:
  test2_multiplier_1: test2/multiplier/schematic, simulator hspiceD
