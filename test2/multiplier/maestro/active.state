ADE simulation setup
Test test2_multiplier_1: test2/multiplier/schematic, simulator hspiceD
Run mode: Single Run, Sweeps and Corners
