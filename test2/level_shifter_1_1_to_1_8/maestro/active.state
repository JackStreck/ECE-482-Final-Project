ADE simulation setup
Test test2_level_shifter_1_1_to_1_8_1: test2/level_shifter_1_1_to_1_8/schematic, simulator hspiceD
Run mode: Single Run, Sweeps and Corners
