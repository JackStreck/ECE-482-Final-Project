ADE simulation setup
Test test2_C2MOS_register_1: test2/C2MOS_register/schematic, simulator hspiceD
