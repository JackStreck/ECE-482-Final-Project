ADE simulation setup
Test test2_superbuffer_4_1: test2/superbuffer_4/av_extracted, simulator hspiceD
Run mode: Single Run, Sweeps and Corners
