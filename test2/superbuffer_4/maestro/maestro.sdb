ADE simulation setup
Run mode: Single Run, Sweeps and Corners
Tests:
  test2_superbuffer_4_1: test2/superbuffer_4/av_extracted, simulator hspiceD
