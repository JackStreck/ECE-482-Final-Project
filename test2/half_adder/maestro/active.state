ADE simulation setup
Test test2_half_adder_1: test2/half_adder/av_extracted, simulator hspiceD
Run mode: Single Run, Sweeps and Corners
