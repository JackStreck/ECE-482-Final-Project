ADE simulation setup
Run mode: Single Run, Sweeps and Corners
Tests:
  test2_half_adder_1: test2/half_adder/av_extracted, simulator hspiceD
