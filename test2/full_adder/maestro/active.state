ADE simulation setup
Test test2_full_adder_1: test2/full_adder/schematic, simulator hspiceD
Run mode: Single Run, Sweeps and Corners
