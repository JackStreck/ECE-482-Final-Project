ADE simulation setup
Test test2_full_adder_1: test2/full_adder/av_extracted, simulator hspiceD
Run mode: Single Run, Sweeps and Corners
