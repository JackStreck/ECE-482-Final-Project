ADE simulation setup
Run mode: Single Run, Sweeps and Corners
Tests:
  test2_full_adder_1: test2/full_adder/schematic, simulator hspiceD
