ADE simulation setup
Test test2_superbuf_stage4_1: test2/superbuf_stage4/av_extracted, simulator hspiceD
Run mode: Single Run, Sweeps and Corners
