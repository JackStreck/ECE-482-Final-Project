ADE simulation setup
Run mode: Single Run, Sweeps and Corners
Tests:
  test2_superbuf_stage4_1: test2/superbuf_stage4/av_extracted, simulator hspiceD
